// Copyright 2026 bazel_rules_hdl Authors
//
// Licensed under the Apache License, Version 2.0 (the "License");
// you may not use this file except in compliance with the License.
// You may obtain a copy of the License at
//
//      http://www.apache.org/licenses/LICENSE-2.0
//
// Unless required by applicable law or agreed to in writing, software
// distributed under the License is distributed on an "AS IS" BASIS,
// WITHOUT WARRANTIES OR CONDITIONS OF ANY KIND, either express or implied.
// See the License for the specific language governing permissions and
// limitations under the License.

addrmap smoke_regs {
    default regwidth = 32;

    reg {
        name = "Smoke control register";
        desc = "Minimal register used by the hermetic generator smoke test.";
        default sw = rw;
        default hw = r;

        field {
            name = "Enable";
            desc = "Enables the smoke-test block.";
        } ENABLE[0:0] = 1'b0;
    } SMOKE_CTRL @0x0;
};
